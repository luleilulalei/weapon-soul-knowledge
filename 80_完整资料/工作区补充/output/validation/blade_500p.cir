blade_500p
Vs drv 0 PULSE(0 5 100n 1n 1n 350n 1.25u)
R27 drv data 330
R28 data 0 100k
Ccable data 0 500p
.options reltol=1e-6 abstol=1e-12
.tran 1n 1.4u
.end
