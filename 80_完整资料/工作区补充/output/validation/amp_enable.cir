amp_enable
Vs gpio 0 PULSE(0 3.192 1m 1u 1u 100m 200m)
R8 gpio sd 2.2k
R9 sd 0 10k
Rinternal sd 0 100k
Cpin sd 0 20p
.options reltol=1e-6 abstol=1e-12
.tran 1u 3m
.end
