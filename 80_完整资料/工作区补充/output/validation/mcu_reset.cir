mcu_reset
Vs supply 0 PWL(0 0 1m 3.192)
R1 supply en 10k
C5 en 0 1u
.options reltol=1e-6 abstol=1e-12
.tran 10u 60m
.end
