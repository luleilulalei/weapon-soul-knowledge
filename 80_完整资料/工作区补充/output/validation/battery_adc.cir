battery_adc
Vs bat 0 PULSE(0 4.2 1m 1u 1u 100m 200m)
R124 bat adc 100k
R125 adc 0 100k
C115 adc 0 100n
.options reltol=1e-6 abstol=1e-12
.tran 10u 50m
.end
